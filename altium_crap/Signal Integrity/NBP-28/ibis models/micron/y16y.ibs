| y16y.ibs * IBIS 3.2 Model
| 256Mb SDRAM - Die Revision "D"
|  Part Number   VDD/VDDQ   Architecture   Package
| MT48LC64M4A2TG   3.3V/3.3V   64 Meg x 4   54-pin TSOP
| MT48LC32M8A2TG   3.3V/3.3V   32 Meg x 8   54-pin TSOP
| MT48LC16M16A2TG   3.3V/3.3V   16 Meg x 16   54-pin TSOP
| MT48LC64M4A2FB   3.3V/3.3V   64 Meg x 4   60-ball FGBA
| MT48LC32M8A2FB   3.3V/3.3V   32 Meg x 8   60-ball FGBA
| MT48LC16M16A2FG   3.3V/3.3V   16 Meg x 16   54-ball VFBGA
[IBIS Ver]   3.2
[File name]   y16y.ibs
[File rev]   2.3
[Date]   06/07/2006
[Source]   From silicon level SPICE model at Micron Technology, Inc.
   Micron Technology, Inc.
   8000 S. Federal Way
   P.O. Box 6, M/S: 01-711
   Boise, ID 83707-0006
[Notes]   Revision History:
   Rev 2.0: 03/03/2003
   - initial file creation
   - I-V curves matched to silicon measurements
   Rev 2.1: 07/31/2003
   - all models updated to match latest process changes
   Rev 2.2: 04/11/2005
   - package parasitics updated for all packages
   - C_comp values updated for all models
   - added clkbuff model for the CLK signal
   Rev 2.3: 06/07/2006
   - updated all models to better match I-V curve measurements
   - typical die temp changed to 40C
[Disclaimer]  This software code and all associated documentation, comments
              or other information (collectively "Software") is provided
              "AS IS" without warranty of any kind. MICRON TECHNOLOGY, INC.
              ("MTI") EXPRESSLY DISCLAIMS ALL WARRANTIES EXPRESS OR IMPLIED,
              INCLUDING BUT NOT LIMITED TO, NONINFRINGEMENT OF THIRD PARTY
              RIGHTS, AND ANY IMPLIED WARRANTIES OF MERCHANTABILITY OR
              FITNESS FOR ANY PARTICULAR PURPOSE. MTI DOES NOT WARRANT THAT
              THE SOFTWARE WILL MEET YOUR REQUIREMENTS, OR THAT THE
              OPERATION OF THE SOFTWARE WILL BE UNINTERRUPTED OR ERROR-FREE.
              FURTHERMORE, MTI DOES NOT MAKE ANY REPRESENTATIONS REGARDING
              THE USE OR THE RESULTS OF THE USE OF THE SOFTWARE IN TERMS OF
              ITS CORRECTNESS, ACCURACY, RELIABILITY, OR OTHERWISE. THE
              ENTIRE RISK ARISING OUT OF USE OR PERFORMANCE OF THE SOFTWARE
              REMAINS WITH YOU. IN NO EVENT SHALL MTI, ITS AFFILIATED
              COMPANIES OR THEIR SUPPLIERS BE LIABLE FOR ANY DIRECT,
              INDIRECT, CONSEQUENTIAL, INCIDENTAL, OR SPECIAL DAMAGES
              (INCLUDING, WITHOUT LIMITATION, DAMAGES FOR LOSS OF PROFITS,
              BUSINESS INTERRUPTION, OR LOSS OF INFORMATION) ARISING OUT OF
              YOUR USE OF OR INABILITY TO USE THE SOFTWARE, EVEN IF MTI HAS
              BEEN ADVISED OF THE POSSIBILITY OF SUCH DAMAGES. Because some
              jurisdictions prohibit the exclusion or limitation of
              liability for consequential or incidental damages, the above
              limitation may not apply to you.
[Copyright]   Copyright 2003 Micron Technology, Inc. All rights reserved.
|   COMPONENT: MT48LC64M4A2TG SDRAM
[Component]   MT48LC64M4A2TG
[Manufacturer]   Micron Technology Inc.
[Package]   | TSOP Package
|variable   typ   min   max
R_pkg   89.3m   82.2m   94.9m
L_pkg   5.17nH   4.08nH   6.72nH
C_pkg   1.22pF   0.94pF   1.49pF
[Pin] signal_name   model_name   R_pin   L_pin   C_pin
1   VDD   POWER   88.1m   7.42nH   1.22pF
2   NC   NC
3   VDDQ   POWER   90.2m   6.42nH   1.48pF
4   NC   NC
5   DQ0   dqbuff   94.5m   5.67nH   1.40pF
6   VSSQ   GND   95.9m   5.48nH   1.31pF
7   NC   NC
8   NC   NC
9   VDDQ   POWER   90.0m   4.77nH   1.16pF
10   NC   NC
11   DQ1   dqbuff   85.2m   4.36nH   1.05pF
12   VSSQ   GND   82.8m   4.17nH   0.98pF
13   NC   NC
14   VDD   POWER   80.5m   4.01nH   0.89pF
15   NC   NC
16   WE   inbuff3   82.2m   4.08nH   0.94pF
17   CAS   inbuff1   84.3m   4.25nH   1.00pF
18   RAS   inbuff1   86.6m   4.45nH   1.08pF
19   CS   inbuff2   88.7m   4.65nH   1.12pF
20   BA0   inbuff1   90.2m   4.86nH   1.18pF
21   BA1   inbuff1   92.8m   5.10nH   1.22pF
22   A10   inbuff1   94.8m   5.35nH   1.27pF
23   A0   inbuff1   93.3m   5.57nH   1.35pF
24   A1   inbuff1   89.8m   5.78nH   1.33pF
25   A2   inbuff1   88.1m   6.26nH   1.42pF
26   A3   inbuff1   90.0m   6.72nH   1.48pF
27   VDD   POWER   81.4m   6.52nH   0.96pF
28   VSS   GND   81.8m   6.56nH   0.96pF
29   A4   inbuff1   90.0m   6.70nH   1.49pF
30   A5   inbuff1   88.3m   6.27nH   1.43pF
31   A6   inbuff1   90.0m   5.80nH   1.35pF
32   A7   inbuff1   93.2m   5.56nH   1.36pF
33   A8   inbuff1   94.9m   5.35nH   1.29pF
34   A9   inbuff1   92.7m   5.11nH   1.23pF
35   A11   inbuff1   90.3m   4.88nH   1.18pF
36   A12   inbuff3   88.8m   4.67nH   1.12pF
37   CKE   inbuff2   86.8m   4.47nH   1.08pF
38   CLK   clkbuff   84.4m   4.27nH   1.01pF
39   DQM   inbuff2   82.4m   4.12nH   0.95pF
40   NC   NC
41   VSS   GND   80.8m   4.02nH   0.90pF
42   NC   NC
43   VDDQ   POWER   82.9m   4.19nH   0.97pF
44   DQ2   dqbuff   85.3m   4.35nH   1.04pF
45   NC   NC
46   VSSQ   GND   90.1m   4.78nH   1.16pF
47   NC   NC
48   NC   NC
49   VDDQ   POWER   96.1m   5.48nH   1.31pF
50   DQ3   dqbuff   94.7m   5.70nH   1.40pF
51   NC   NC
52   VSSQ   GND   90.5m   6.44nH   1.49pF
53   NC   NC
54   VSS   GND   88.3m   7.46nH   1.23pF
|   COMPONENT: MT48LC32M8A2TG SDRAM
[Component]   MT48LC32M8A2TG
[Manufacturer]   Micron Technology Inc.
[Package]   | TSOP Package
|variable   typ   min   max
R_pkg   89.8m   82.2m   94.9m
L_pkg   5.27nH   4.08nH   6.92nH
C_pkg   1.24pF   0.94pF   1.57pF
[Pin] signal_name   model_name   R_pin   L_pin   C_pin
1   VDD   POWER   88.1m   7.42nH   1.22pF
2   DQ0   dqbuff   93.9m   6.92nH   1.57pF
3   VDDQ   POWER   90.2m   6.42nH   1.48pF
4   NC   NC
5   DQ1   dqbuff   94.5m   5.67nH   1.40pF
6   VSSQ   GND   95.9m   5.48nH   1.31pF
7   NC   NC
8   DQ2   dqbuff   91.7m   4.99nH   1.21pF
9   VDDQ   POWER   90.0m   4.77nH   1.16pF
10   NC   NC
11   DQ3   dqbuff   85.2m   4.36nH   1.05pF
12   VSSQ   GND   82.8m   4.17nH   0.98pF
13   NC   NC
14   VDD   POWER   80.5m   4.01nH   0.89pF
15   NC   NC
16   WE   inbuff3   82.2m   4.08nH   0.94pF
17   CAS   inbuff1   84.3m   4.25nH   1.00pF
18   RAS   inbuff1   86.6m   4.45nH   1.08pF
19   CS   inbuff2   88.7m   4.65nH   1.12pF
20   BA0   inbuff1   90.2m   4.86nH   1.18pF
21   BA1   inbuff1   92.8m   5.10nH   1.22pF
22   A10   inbuff1   94.8m   5.35nH   1.27pF
23   A0   inbuff1   93.3m   5.57nH   1.35pF
24   A1   inbuff1   89.8m   5.78nH   1.33pF
25   A2   inbuff1   88.1m   6.26nH   1.42pF
26   A3   inbuff1   90.0m   6.72nH   1.48pF
27   VDD   POWER   81.4m   6.52nH   0.96pF
28   VSS   GND   81.8m   6.56nH   0.96pF
29   A4   inbuff1   90.0m   6.70nH   1.49pF
30   A5   inbuff1   88.3m   6.27nH   1.43pF
31   A6   inbuff1   90.0m   5.80nH   1.35pF
32   A7   inbuff1   93.2m   5.56nH   1.36pF
33   A8   inbuff1   94.9m   5.35nH   1.29pF
34   A9   inbuff1   92.7m   5.11nH   1.23pF
35   A11   inbuff1   90.3m   4.88nH   1.18pF
36   A12   inbuff3   88.8m   4.67nH   1.12pF
37   CKE   inbuff2   86.8m   4.47nH   1.08pF
38   CLK   clkbuff   84.4m   4.27nH   1.01pF
39   DQM   inbuff2   82.4m   4.12nH   0.95pF
40   NC   NC
41   VSS   GND   80.8m   4.02nH   0.90pF
42   NC   NC
43   VDDQ   POWER   82.9m   4.19nH   0.97pF
44   DQ4   dqbuff   85.3m   4.35nH   1.04pF
45   NC   NC
46   VSSQ   GND   90.1m   4.78nH   1.16pF
47   DQ5   dqbuff   91.7m   5.00nH   1.21pF
48   NC   NC
49   VDDQ   POWER   96.1m   5.48nH   1.31pF
50   DQ6   dqbuff   94.7m   5.70nH   1.40pF
51   NC   NC
52   VSSQ   GND   90.5m   6.44nH   1.49pF
53   DQ7   dqbuff   94.0m   6.92nH   1.57pF
54   VSS   GND   88.3m   7.46nH   1.23pF
|   COMPONENT: MT48LC16M16A2TG SDRAM
[Component]   MT48LC16M16A2TG
[Manufacturer]   Micron Technology Inc.
[Package]   | TSOP Package
|variable   typ   min   max
R_pkg   89.3m   81.2m   94.9m
L_pkg   5.17nH   4.01nH   6.92nH
C_pkg   1.22pF   0.90pF   1.57pF
[Pin] signal_name   model_name   R_pin   L_pin   C_pin
1   VDD   POWER   88.1m   7.42nH   1.22pF
2   DQ0   dqbuff   93.9m   6.92nH   1.57pF
3   VDDQ   POWER   90.2m   6.42nH   1.48pF
4   DQ1   dqbuff   91.1m   5.91nH   1.38pF
5   DQ2   dqbuff   94.5m   5.67nH   1.40pF
6   VSSQ   GND   95.9m   5.48nH   1.31pF
7   DQ3   dqbuff   93.4m   5.23nH   1.28pF
8   DQ4   dqbuff   91.7m   4.99nH   1.21pF
9   VDDQ   POWER   90.0m   4.77nH   1.16pF
10   DQ5   dqbuff   87.8m   4.54nH   1.10pF
11   DQ6   dqbuff   85.2m   4.36nH   1.05pF
12   VSSQ   GND   82.8m   4.17nH   0.98pF
13   DQ7   dqbuff   81.5m   4.09nH   0.91pF
14   VDD   POWER   80.5m   4.01nH   0.89pF
15   DQML   inbuff2   81.2m   4.01nH   0.90pF
16   WE   inbuff3   82.2m   4.08nH   0.94pF
17   CAS   inbuff1   84.3m   4.25nH   1.00pF
18   RAS   inbuff1   86.6m   4.45nH   1.08pF
19   CS   inbuff2   88.7m   4.65nH   1.12pF
20   BA0   inbuff1   90.2m   4.86nH   1.18pF
21   BA1   inbuff1   92.8m   5.10nH   1.22pF
22   A10   inbuff1   94.8m   5.35nH   1.27pF
23   A0   inbuff1   93.3m   5.57nH   1.35pF
24   A1   inbuff1   89.8m   5.78nH   1.33pF
25   A2   inbuff1   88.1m   6.26nH   1.42pF
26   A3   inbuff1   90.0m   6.72nH   1.48pF
27   VDD   POWER   81.4m   6.52nH   0.96pF
28   VSS   GND   81.8m   6.56nH   0.96pF
29   A4   inbuff1   90.0m   6.70nH   1.49pF
30   A5   inbuff1   88.3m   6.27nH   1.43pF
31   A6   inbuff1   90.0m   5.80nH   1.35pF
32   A7   inbuff1   93.2m   5.56nH   1.36pF
33   A8   inbuff1   94.9m   5.35nH   1.29pF
34   A9   inbuff1   92.7m   5.11nH   1.23pF
35   A11   inbuff1   90.3m   4.88nH   1.18pF
36   A12   inbuff3   88.8m   4.67nH   1.12pF
37   CKE   inbuff2   86.8m   4.47nH   1.08pF
38   CLK   clkbuff   84.4m   4.27nH   1.01pF
39   DQMH   inbuff2   82.4m   4.12nH   0.95pF
40   NC   NC
41   VSS   GND   80.8m   4.02nH   0.90pF
42   DQ8   dqbuff   81.5m   4.08nH   0.91pF
43   VDDQ   POWER   82.9m   4.19nH   0.97pF
44   DQ9   dqbuff   85.3m   4.35nH   1.04pF
45   DQ10   dqbuff   87.9m   4.56nH   1.10pF
46   VSSQ   GND   90.1m   4.78nH   1.16pF
47   DQ11   dqbuff   91.7m   5.00nH   1.21pF
48   DQ12   dqbuff   93.6m   5.23nH   1.28pF
49   VDDQ   POWER   96.1m   5.48nH   1.31pF
50   DQ13   dqbuff   94.7m   5.70nH   1.40pF
51   DQ14   dqbuff   91.3m   5.94nH   1.39pF
52   VSSQ   GND   90.5m   6.44nH   1.49pF
53   DQ15   dqbuff   94.0m   6.92nH   1.57pF
54   VSS   GND   88.3m   7.46nH   1.23pF
|   COMPONENT: MT48LC64M4A2FB SDRAM
[Component]   MT48LC64M4A2FB
[Manufacturer]   Micron Technology Inc.
[Package]   | 8mm x 16mm FBGA
|variable   typ   min   max
R_pkg   62m   34m   81m
L_pkg   2.24nH   1.45nH   3.25nH
C_pkg   0.46pF   0.37pF   0.54pF
[Pin]  signal_name   model_name   R_pin   L_pin   C_pin
A1   NC   NC
A2   VSS   GND   265m   2.48nH   2.85pF
A7   VDD   POWER   284m   3.08nH   0.42pF
A8   NC   NC
B1   NC   NC
B2   VSSQ   GND   273m   1.65nH   0.46pF
B7   VDDQ   POWER   277m   1.87nH   0.49pF
B8   NC   NC
C1   VDDQ   POWER   281m   3.15nH   0.49pF
C2   DQ3   dqbuff   300m   3.62nH   0.47pF
C7   DQ0   dqbuff   278m   3.87nH   0.51pF
C8   VSSQ   GND   278m   1.98nH   0.46pF
D1   NC   NC
D2   NC   NC
D7   NC   NC
D8   NC   NC
E1   NC   NC
E2   VSSQ   GND   293m   3.63nH   0.46pF
E7   VDDQ   POWER   282m   1.98nH   0.49pF
E8   NC   NC
F1   VDDQ   POWER   247m   2.11nH   0.49pF
F2   DQ2   dqbuff   290m   3.43nH   0.40pF
F7   DQ1   dqbuff   288m   3.22nH   0.38pF
F8   VSSQ   GND   277m   2.25nH   0.46pF
G1   NC   NC
G2   NC   NC
G7   NC   NC
G8   NC   NC
H1   NC   NC
H2   VSS   GND   235m   2.78nH   2.85pF
H7   VDD   POWER   239m   1.59nH   0.42pF
H8   NC   NC
J1   NC   NC
J2   DQM   inbuff2   290m   3.19nH   0.40pF
J7   WE#   inbuff3   293m   3.23nH   0.39pF
J8   CAS#   inbuff1   298m   3.47nH   0.40pF
K1   NC   NC
K2   CLK   clkbuff   286m   3.00nH   0.37pF
K7   RAS#   inbuff1   294m   3.37nH   0.39pF
K8   NC   NC
L1   A12   inbuff3   311m   4.39nH   0.51pF
L2   CKE   inbuff2   287m   3.20nH   0.39pF
L7   NC   NC
L8   CS#   inbuff2   294m   3.61nH   0.38pF
M1   A11   inbuff1   292m   3.60nH   0.44pF
M2   A9   inbuff1   297m   3.69nH   0.45pF
M7   BA1   inbuff1   300m   3.65nH   0.40pF
M8   BA0   inbuff1   300m   3.68nH   0.41pF
N1   A8   inbuff1   302m   4.01nH   0.48pF
N2   A7   inbuff1   287m   3.39nH   0.40pF
N7   A0   inbuff1   271m   3.69nH   0.44pF
N8   A10   inbuff1   301m   3.65nH   0.43pF
P1   A6   inbuff1   316m   4.37nH   0.52pF
P2   A5   inbuff1   260m   3.44nH   0.42pF
P7   A2   inbuff1   282m   4.41nH   0.52pF
P8   A1   inbuff1   291m   4.51nH   0.52pF
R1   A4   inbuff1   272m   4.42nH   0.54pF
R2   VSS   GND   238m   3.08nH   2.85pF
R7   VDD   POWER   256m   2.00nH   0.42pF
R8   A3   inbuff1   257m   3.58nH   0.41pF
|   COMPONENT: MT48LC32M8A2FB SDRAM
[Component]   MT48LC32M8A2FB
[Manufacturer]   Micron Technology Inc.
[Package]   | 8mm x 16mm FBGA
|variable   typ   min   max
R_pkg   63m   34m   81m
L_pkg   2.28nH   1.45nH   3.25nH
C_pkg   0.46pF   0.37pF   0.54pF
[Pin]  signal_name   model_name   R_pin   L_pin   C_pin
A1   DQ7   dqbuff   296m   4.58nH   0.62pF
A2   VSS   GND   265m   2.48nH   2.85pF
A7   VDD   POWER   284m   3.08nH   0.42pF
A8   DQ0   dqbuff   287m   4.87nH   0.56pF
B1   NC   NC
B2   VSSQ   GND   273m   1.65nH   0.46pF
B7   VDDQ   POWER   277m   1.87nH   0.49pF
B8   NC   NC
C1   VDDQ   POWER   281m   3.15nH   0.49pF
C2   DQ6   dqbuff   300m   3.62nH   0.47pF
C7   DQ1   dqbuff   278m   3.87nH   0.51pF
C8   VSSQ   GND   278m   1.98nH   0.46pF
D1   DQ5   dqbuff   306m   4.05nH   0.50pF
D2   NC   NC
D7   NC   NC
D8   DQ2   dqbuff   293m   3.58nH   0.44pF
E1   NC   NC
E2   VSSQ   GND   293m   3.63nH   0.46pF
E7   VDDQ   POWER   282m   1.98nH   0.49pF
E8   NC   NC
F1   VDDQ   POWER   247m   2.11nH   0.49pF
F2   DQ4   dqbuff   290m   3.43nH   0.40pF
F7   DQ3   dqbuff   288m   3.22nH   0.38pF
F8   VSSQ   GND   277m   2.25nH   0.46pF
G1   NC   NC
G2   NC   NC
G7   NC   NC
G8   NC   NC
H1   NC   NC
H2   VSS   GND   235m   2.78nH   2.85pF
H7   VDD   POWER   239m   1.59nH   0.42pF
H8   NC   NC
J1   NC   NC
J2   DQM   inbuff2   290m   3.19nH   0.40pF
J7   WE#   inbuff3   293m   3.23nH   0.39pF
J8   CAS#   inbuff1   298m   3.47nH   0.40pF
K1   NC   NC
K2   CLK   clkbuff   286m   3.00nH   0.37pF
K7   RAS#   inbuff1   294m   3.37nH   0.39pF
K8   NC   NC
L1   A12   inbuff3   311m   4.39nH   0.51pF
L2   CKE   inbuff2   287m   3.20nH   0.39pF
L7   NC   NC
L8   CS#   inbuff2   294m   3.61nH   0.38pF
M1   A11   inbuff1   292m   3.60nH   0.44pF
M2   A9   inbuff1   297m   3.69nH   0.45pF
M7   BA1   inbuff1   300m   3.65nH   0.40pF
M8   BA0   inbuff1   300m   3.68nH   0.41pF
N1   A8   inbuff1   302m   4.01nH   0.48pF
N2   A7   inbuff1   287m   3.39nH   0.40pF
N7   A0   inbuff1   271m   3.69nH   0.44pF
N8   A10   inbuff1   301m   3.65nH   0.43pF
P1   A6   inbuff1   316m   4.37nH   0.52pF
P2   A5   inbuff1   260m   3.44nH   0.42pF
P7   A2   inbuff1   282m   4.41nH   0.52pF
P8   A1   inbuff1   291m   4.51nH   0.52pF
R1   A4   inbuff1   272m   4.42nH   0.54pF
R2   VSS   GND   238m   3.08nH   2.85pF
R7   VDD   POWER   256m   2.00nH   0.42pF
R8   A3   inbuff1   257m   3.58nH   0.41pF
|   COMPONENT: MT48LC16M16A2FG SDRAM
[Component]   MT48LC16M16A2FG
[Manufacturer]   Micron Technology Inc.
[Package]   | 8mm x 14mm VFBGA
|variable   typ   min   max
R_pkg   61m   44m   83m
L_pkg   2.11nH   1.22nH   3.25nH
C_pkg   0.24pf   0.16pf   0.33pf
[Pin]  signal_name   model_name   R_pin   L_pin   C_pin
A1   VSS   GND   244m   2.27nH   0.93pF
A2   DQ15   dqbuff   259m   2.73nH   0.21pF
A3   VSSQ   GND   268m   2.72nH   0.21pF
A7   VDDQ   POWER   268m   2.85nH   0.23pF
A8   DQ0   dqbuff   258m   2.54nH   0.20pF
A9   VDD   POWER   272m   3.19nH   0.28pF
B1   DQ14   dqbuff   265m   2.81nH   0.21pF
B2   DQ13   dqbuff   277m   2.99nH   0.22pF
B3   VDDQ   POWER   270m   2.76nH   0.22pF
B7   VSSQ   GND   270m   2.84nH   0.22pF
B8   DQ2   dqbuff   276m   2.99nH   0.21pF
B9   DQ1   dqbuff   266m   2.95nH   0.21pF
C1   DQ12   dqbuff   266m   2.93nH   0.20pF
C2   DQ11   dqbuff   278m   3.02nH   0.22pF
C3   VSSQ   GND   270m   2.77nH   0.23pF
C7   VDDQ   POWER   271m   2.84nH   0.23pF
C8   DQ4   dqbuff   280m   3.16nH   0.22pF
C9   DQ3   dqbuff   265m   2.98nH   0.21pF
D1   DQ10   dqbuff   265m   2.88nH   0.21pF
D2   DQ9   dqbuff   278m   3.01nH   0.22pF
D3   VDDQ   POWER   267m   2.70nH   0.22pF
D7   VSSQ   GND   268m   2.77nH   0.22pF
D8   DQ6   dqbuff   276m   2.97nH   0.22pF
D9   DQ5   dqbuff   266m   2.96nH   0.21pF
E1   DQ8   dqbuff   263m   2.75nH   0.21pF
E2   NC   NC
E3   VSS   GND   247m   2.75nH   0.93pF
E7   VDD   POWER   275m   3.16nH   0.28pF
E8   LDQM   inbuff2   283m   3.42nH   0.23pF
E9   DQ7   dqbuff   266m   2.98nH   0.21pF
F1   UDQM   inbuff2   266m   2.95nH   0.21pF
F2   CLK   clkbuff   255m   2.47nH   0.20pF
F3   CKE   inbuff2   273m   3.04nH   0.23pF
F7   CAS   inbuff1   277m   3.36nH   0.24pF
F8   RAS   inbuff1   280m   3.34nH   0.23pF
F9   WE   inbuff3   266m   2.99nH   0.21pF
G1   A12   inbuff3   266m   2.85nH   0.20pF
G2   A11   inbuff1   289m   3.69nH   0.25pF
G3   A9   inbuff1   268m   2.86nH   0.23pF
G7   BA0   inbuff1   271m   3.16nH   0.23pF
G8   BA1   inbuff1   279m   3.37nH   0.22pF
G9   CS   inbuff2   268m   3.03nH   0.21pF
H1   A8   inbuff1   266m   2.97nH   0.21pF
H2   A7   inbuff1   280m   3.67nH   0.24pF
H3   A6   inbuff1   282m   3.67nH   0.25pF
H7   A0   inbuff1   267m   2.77nH   0.22pF
H8   A1   inbuff1   257m   2.56nH   0.21pF
H9   A10   inbuff1   266m   2.98nH   0.21pF
J1   VSS   GND   255m   2.65nH   0.93pF
J2   A5   inbuff1   257m   2.69nH   0.21pF
J3   A4   inbuff1   277m   3.34nH   0.24pF
J7   A3   inbuff1   260m   2.68nH   0.22pF
J8   A2   inbuff1   255m   2.49nH   0.20pF
J9   VDD   POWER   279m   3.23nH   0.28pF
| Models and submodels in the file (5): dqbuff (I/O), inbuff1 (Input), inbuff2 (Input), inbuff3 (Input), clkbuff (Input)
