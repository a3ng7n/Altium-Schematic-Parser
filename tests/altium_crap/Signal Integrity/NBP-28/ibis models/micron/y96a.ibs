|   * y96a.ibs * IBIS 3.2 Model for 256Mb SDRAM
[IBIS Ver]   3.2
[Comment char]  |_char
[File name]   y96a.ibs
[Date]   04/08/2003
[File Rev]   2.8
[Source]   From silicon level SPICE model at Micron Technology, Inc.
   Micron Technology, Inc.
   8000 S. Federal Way
   P.O. Box 6, M/S: 711
   Boise, ID 83707-0006
[Notes]   Rev 1.1 changes:
   - updated C_comp values 09/12/2000
   Rev 2.0 changes 10/26/2000
   - dq model I-V curves matched to silicon measurements
   Rev 2.1 changes 01/22/2001
   - clamp curves adjusted to better match measurements
   - added input2 model for A12 & WE inputs
   Rev 2.2 changes 06/13/2001
   - i/o and input models matched to new measurements
   - preliminary FBGA packages added
   Rev 2.3 changes 07/06/2001
   - FBGA package parasitics updated with latest sim data
   Rev 2.4 changes 10/15/2001
   - FBGA pins renumbered with alpha-numeric system
   - pin 12 on TSOPs model name changed from gnd to GND
   Rev 2.5 changes 11/16/2001
   - dq model updated to match drive strength reduction
   - added capacitance for ESD devices
   Rev 2.6 changes 01/21/2002
   - dq model updated due to drive strength increase
   Rev 2.7 changes: 02/18/2002
   - FBGA package pinout error fixed
   Rev 2.8 changes: 04/08/2003
   - Updated all models to match input capacitance
[Disclaimer] THESE DESIGNS ARE PROVIDED "AS IS" WITH NO WARRANTY
                WHATSOEVER AND MICRON SPECIFICALLY DISCLAIMS ANY
                IMPLIED WARRANTIES OF MERCHANTABILITY, FITNESS FOR
                A PARTICULAR PURPOSE, OR AGAINST INFRINGEMENT.
                Copyright 2001, Micron Technology, Inc.
|   COMPONENT: MT48LC16M16A2TG
[Component]   MT48LC16M16A2TG
[Manufacturer]  Micron Technology, Inc.
[Package]   | TSOP Package
|variable   typ   min   max
R_pkg   265.11m   210m   326m
L_pkg   5.82nH   4.67nH   7.87nH
C_pkg   1.048pF   .773pF   1.620pF
[Pin] signal_name   model_name   R_pin   L_pin   C_pin
   1   VDD   POWER   251m   6.97nH   1.00pF
   2   DQ0   dq   291m   6.72nH   1.11pF
   3   VDDQ   POWER   282m   6.35nH   1.28pF
   4   DQ1   dq   247m   6.11nH   1.43pF
   5   DQ2   dq   286m   6.03nH   1.12pF
   6   VSSQ   GND   279m   5.85nH   1.05pF
   7   DQ3   dq   268m   5.56nH   1.00pF
   8   DQ4   dq   251m   5.22nH   0.93pF
   9   VDDQ   POWER   245m   5.11nH   0.87pF
   10   DQ5   dq   232m   4.87nH   0.87pF
   11   DQ6   dq   233m   4.83nH   0.82pF
   12   VSSQ   GND   229m   4.75nH   0.80pF
   13   DQ7   dq   227m   4.72nH   0.80pF
   14   VDD   POWER   211m   4.67nH   1.09pF
   15   DQML   input   229m   4.79nH   0.84pF
   16   WE#   input2   239m   4.94nH   0.86pF
   17   CAS#   input   244m   5.05nH   0.89pF
   18   RAS#   input   257m   5.28nH   0.94pF
   19   CS#   input   268m   5.53nH   0.99pF
   20   BA0   input   293m   5.85nH   1.01pF
   21   BA1   input   302m   6.10nH   1.10pF
   22   A10   input   305m   6.34nH   1.19pF
   23   A0   input   325m   6.66nH   1.17pF
   24   A1   input   261m   6.63nH   1.62pF
   25   A2   input   309m   7.20nH   1.38pF
   26   A3   input   312m   7.47nH   1.25pF
   27   VDD   POWER   272m   7.87nH   1.00pF
   28   VSS   GND   270m   7.87nH   0.97pF
   29   A4   input   311m   7.45nH   1.28pF
   30   A5   input   309m   7.18nH   1.38pF
   31   A6   input   262m   6.64nH   1.54pF
   32   A7   input   326m   6.63nH   1.21pF
   33   A8   input   306m   6.36nH   1.17pF
   34   A9   input   302m   6.09nH   1.08pF
   35   A11   input   291m   5.86nH   1.02pF
   36   A12   input2   266m   5.52nH   0.96pF
   37   CKE   input   255m   5.29nH   0.91pF
   38   CLK   clk_input   246m   5.14nH   0.88pF
   39   DQMH   input   236m   4.98nH   0.84pF
   40   NC   NC   NA   NA   NA
   41   VSS   GND   210m   4.70nH   1.09pF
   42   DQ8   dq   224m   4.79nH   0.77pF
   43   VDDQ   POWER   228m   4.79nH   0.79pF
   44   DQ9   dq   232m   4.83nH   0.81pF
   45   DQ10   dq   235m   4.90nH   0.86pF
   46   VSSQ   GND   246m   5.12nH   0.89pF
   47   DQ11   dq   258m   5.31nH   0.95pF
   48   DQ12   dq   277m   5.58nH   0.99pF
   49   VDDQ   POWER   281m   4.79nH   1.06pF
   50   DQ13   dq   292m   6.10nH   1.12pF
   51   DQ14   dq   246m   6.07nH   1.41pF
   52   VSSQ   GND   282m   6.32nH   1.27pF
   53   DQ15   dq   293m   6.73nH   1.09pF
   54   VSS   GND   253m   6.98nH   1.00pF
|   COMPONENT: MT48LC32M8A2TG
[Component]   MT48LC32M8A2TG
[Manufacturer]  Micron Technology, Inc.
[Package]   | TSOP Package
|variable   typ   min   max
R_pkg   265.11m   210m   326m
L_pkg   5.82nH   4.67nH   7.87nH
C_pkg   1.048pF   .773pF   1.620pF
[Pin] signal_name   model_name   R_pin   L_pin   C_pin
   1   VDD   POWER   251m   6.97nH   1.00pF
   2   DQ0   dq   291m   6.72nH   1.11pF
   3   VDDQ   POWER   282m   6.35nH   1.28pF
   4   NC   NC   NA   NA   NA
   5   DQ1   dq   286m   6.03nH   1.12pF
   6   VSSQ   GND   279m   5.85nH   1.05pF
   7   NC   NC   NA   NA   NA
   8   DQ2   dq   251m   5.22nH   0.93pF
   9   VDDQ   POWER   245m   5.11nH   0.87pF
   10   NC   NC   NA   NA   NA
   11   DQ3   dq   233m   4.83nH   0.82pF
   12   VSSQ   GND   229m   4.75nH   0.80pF
   13   NC   NC   NA   NA   NA
   14   VDD   POWER   211m   4.67nH   1.09pF
   15   NC   NC   NA   NA   NA
   16   WE#   input2   239m   4.94nH   0.86pF
   17   CAS#   input   244m   5.05nH   0.89pF
   18   RAS#   input   257m   5.28nH   0.94pF
   19   CS#   input   268m   5.53nH   0.99pF
   20   BA0   input   293m   5.85nH   1.01pF
   21   BA1   input   302m   6.10nH   1.10pF
   22   A10   input   305m   6.34nH   1.19pF
   23   A0   input   325m   6.66nH   1.17pF
   24   A1   input   261m   6.63nH   1.62pF
   25   A2   input   309m   7.20nH   1.38pF
   26   A3   input   312m   7.47nH   1.25pF
   27   VDD   POWER   272m   7.87nH   1.00pF
   28   VSS   GND   270m   7.87nH   0.97pF
   29   A4   input   311m   7.45nH   1.28pF
   30   A5   input   309m   7.18nH   1.38pF
   31   A6   input   262m   6.64nH   1.54pF
   32   A7   input   326m   6.63nH   1.21pF
   33   A8   input   306m   6.36nH   1.17pF
   34   A9   input   302m   6.09nH   1.08pF
   35   A11   input   291m   5.86nH   1.02pF
   36   A12   input2   266m   5.52nH   0.96pF
   37   CKE   input   255m   5.29nH   0.91pF
   38   CLK   clk_input   246m   5.14nH   0.88pF
   39   DQM   input   236m   4.98nH   0.84pF
   40   NC   NC   NA   NA   NA
   41   VSS   GND   210m   4.70nH   1.09pF
   42   NC   NC   NA   NA   NA
   43   VDDQ   POWER   228m   4.79nH   0.79pF
   44   DQ4   dq   232m   4.83nH   0.81pF
   45   NC   NC   NA   NA   NA
   46   VSSQ   GND   246m   5.12nH   0.89pF
   47   DQ5   dq   258m   5.31nH   0.95pF
   48   NC   NC   NA   NA   NA
   49   VDDQ   POWER   281m   4.79nH   1.06pF
   50   DQ6   dq   292m   6.10nH   1.12pF
   51   NC   NC   NA   NA   NA
   52   VSSQ   GND   282m   6.32nH   1.27pF
   53   DQ7   dq   293m   6.73nH   1.09pF
   54   VSS   GND   253m   6.98nH   1.00pF
|   COMPONENT: MT48LC64M4A2TG
[Component]   MT48LC64M4A2TG
[Manufacturer]  Micron Technology, Inc.
[Package]   | TSOP Package
|variable   typ   min   max
R_pkg   265.11m   210m   326m
L_pkg   5.82nH   4.67nH   7.87nH
C_pkg   1.048pF   .773pF   1.620pF
[Pin] signal_name   model_name   R_pin   L_pin   C_pin
   1   VDD   POWER   251m   6.97nH   1.00pF
   2   NC   NC   NA   NA   NA
   3   VDDQ   POWER   282m   6.35nH   1.28pF
   4   NC   NC   NA   NA   NA
   5   DQ0   dq   286m   6.03nH   1.12pF
   6   VSSQ   GND   279m   5.85nH   1.05pF
   7   NC   NC   NA   NA   NA
   8   NC   NC   NA   NA   NA
   9   VDDQ   POWER   245m   5.11nH   0.87pF
   10   NC   NC   NA   NA   NA
   11   DQ1   dq   233m   4.83nH   0.82pF
   12   VSSQ   GND   229m   4.75nH   0.80pF
   13   NC   NC   NA   NA   NA
   14   VDD   POWER   211m   4.67nH   1.09pF
   15   NC   NC   NA   NA   NA
   16   WE#   input2   239m   4.94nH   0.86pF
   17   CAS#   input   244m   5.05nH   0.89pF
   18   RAS#   input   257m   5.28nH   0.94pF
   19   CS#   input   268m   5.53nH   0.99pF
   20   BA0   input   293m   5.85nH   1.01pF
   21   BA1   input   302m   6.10nH   1.10pF
   22   A10   input   305m   6.34nH   1.19pF
   23   A0   input   325m   6.66nH   1.17pF
   24   A1   input   261m   6.63nH   1.62pF
   25   A2   input   309m   7.20nH   1.38pF
   26   A3   input   312m   7.47nH   1.25pF
   27   VDD   POWER   272m   7.87nH   1.00pF
   28   VSS   GND   270m   7.87nH   0.97pF
   29   A4   input   311m   7.45nH   1.28pF
   30   A5   input   309m   7.18nH   1.38pF
   31   A6   input   262m   6.64nH   1.54pF
   32   A7   input   326m   6.63nH   1.21pF
   33   A8   input   306m   6.36nH   1.17pF
   34   A9   input   302m   6.09nH   1.08pF
   35   A11   input   291m   5.86nH   1.02pF
   36   A12   input2   266m   5.52nH   0.96pF
   37   CKE   input   255m   5.29nH   0.91pF
   38   CLK   clk_input   246m   5.14nH   0.88pF
   39   DQM   input   236m   4.98nH   0.84pF
   40   NC   NC   NA   NA   NA
   41   VSS   GND   210m   4.70nH   1.09pF
   42   NC   NC   NA   NA   NA
   43   VDDQ   POWER   228m   4.79nH   0.79pF
   44   DQ2   dq   232m   4.83nH   0.81pF
   45   NC   NC   NA   NA   NA
   46   VSSQ   GND   246m   5.12nH   0.89pF
   47   NC   NC   NA   NA   NA
   48   NC   NC   NA   NA   NA
   49   VDDQ   POWER   281m   4.79nH   1.06pF
   50   DQ3   dq   292m   6.10nH   1.12pF
   51   NC   NC   NA   NA   NA
   52   VSSQ   GND   282m   6.32nH   1.27pF
   53   NC   NC   NA   NA   NA
   54   VSS   GND   253m   6.98nH   1.00pF
|   COMPONENT: MT48LC32M8A2FB SDRAM
[Component]   MT48LC32M8A2FB
[Manufacturer]  Micron Technology, Inc.
[Package]   | FBGA Package
|   typ   min   max
R_pkg   75m   40m   93m
L_pkg   2.51nH   1.4nH   3.59nH
C_pkg   0.35pF   0.24pF   0.42pF
[Pin]  signal_name   model_name   R_pin   L_pin   C_pin
A1   DQ7   dq   83m   2.95nH   0.32pF
A2   VSS   GND   41m   1.45nH   0.33pF
A7   VDD   POWER   41m   1.43nH   0.33pF
A8   DQ0   dq   81m   2.86nH   0.32pF
B1   NC   NC   NA   NA   NA
B2   VSSQ   GND   66m   2.00nH   0.33pF
B7   VDDQ   POWER   65m   1.93nH   0.32pF
B8   NC   NC   NA   NA   NA
C1   VDDQ   POWER   82m   2.94nH   0.33pF
C2   DQ6   dq   68m   2.09nH   0.32pF
C7   DQ1   dq   68m   2.06nH   0.32pF
C8   VSSQ   GND   83m   2.93nH   0.33pF
D1   DQ5   dq   81m   2.87nH   0.32pF
D2   NC   NC   NA   NA   NA
D7   NC   NC   NA   NA   NA
D8   DQ2   dq   80m   2.83nH   0.32pF
E1   NC   NC   NA   NA   NA
E2   VSSQ   GND   66m   1.95nH   0.31pF
E7   VDDQ   POWER   65m   1.91nH   0.32pF
E8   NC   NC   NA   NA   NA
F1   VDDQ   POWER   78m   2.76nH   0.31pF
F2   DQ4   dq   64m   1.91nH   0.31pF
F7   DQ3   dq   63m   1.85nH   0.31pF
F8   VSSQ   GND   77m   2.71nH   0.31pF
G1   NC   NC   NA   NA   NA
G2   NC   NC   NA   NA   NA
G7   NC   NC   NA   NA   NA
G8   NC   NC   NA   NA   NA
H1   NC   NC   NA   NA   NA
H2   VSS   GND   65m   1.86nH   0.30pF
H7   VDD   POWER   67m   1.97nH   0.35pF
H8   NC   NC   NA   NA   NA
J1   NC   NC   NA   NA   NA
J2   DQM   input   67m   1.98nH   0.29pF
J7   WE#   input2   68m   1.98nH   0.24pF
J8   CAS#   input   83m   2.86nH   0.28pF
K1   NC   NC   NA   NA   NA
K2   CLK   clk_input   71m   2.20nH   0.31pF
K7   RAS#   input   70m   2.10nH   0.35pF
K8   NC   NC   NA   NA   NA
L1   A12   input2   93m   3.23nH   0.42pF
L2   CKE   input   76m   2.50nH   0.38pF
L7   NC   NC   NA   NA   NA
L8   CS#   input   84m   3.02nH   0.33pF
M1   A11   input   91m   3.23nH   0.41pF
M2   A9   input   76m   2.37nH   0.40pF
M7   BA1   input   76m   2.47nH   0.40pF
M8   BA0   input   90m   3.33nH   0.36pF
N1   A8   input   90m   3.32nH   0.40pF
N2   A7   input   76m   2.46nH   0.40pF
N7   A0   input   78m   2.54nH   0.41pF
N8   A10   input   93m   3.43nH   0.41pF
P1   A6   input   90m   3.37nH   0.39pF
P2   A5   input   76m   2.52nH   0.39pF
P7   A2   input   78m   2.63nH   0.40pF
P8   A1   input   93m   3.52nH   0.41pF
Q1   A4   input   91m   3.49nH   0.37pF
Q2   VSS   GND   43m   1.49nH   0.35pF
Q7   VDD   POWER   40m   1.40nH   0.35pF
Q8   A3   input   93m   3.59nH   0.38pF
|   COMPONENT: MT48LC64M4A2FB SDRAM
[Component]   MT48LC64M4A2FB
[Manufacturer]  Micron Technology, Inc.
[Package]   | FBGA Package
|   typ   min   max
R_pkg   74m   40m   93m
L_pkg   2.50nH   1.40nH   3.59nH
C_pkg   0.35pF   0.24pF   0.42pF
[Pin]  signal_name   model_name   R_pin   L_pin   C_pin
A1   NC   NC   NA   NA   NA
A2   VSS   GND   41m   1.45nH   0.33pF
A7   VDD   POWER   41m   1.43nH   0.33pF
A8   NC   NC   NA   NA   NA
B1   NC   NC   NA   NA   NA
B2   VSSQ   GND   66m   2.00nH   0.33pF
B7   VDDQ   POWER   65m   1.93nH   0.32pF
B8   NC   NC   NA   NA   NA
C1   VDDQ   POWER   82m   2.94nH   0.33pF
C2   DQ3   dq   68m   2.09nH   0.32pF
C7   DQ0   dq   68m   2.06nH   0.32pF
C8   VSSQ   GND   83m   2.93nH   0.33pF
D1   NC   NC   NA   NA   NA
D2   NC   NC   NA   NA   NA
D7   NC   NC   NA   NA   NA
D8   NC   NC   NA   NA   NA
E1   NC   NC   NA   NA   NA
E2   VSSQ   GND   66m   1.95nH   0.31pF
E7   VDDQ   POWER   65m   1.91nH   0.32pF
E8   NC   NC   NA   NA   NA
F1   VDDQ   POWER   78m   2.76nH   0.31pF
F2   DQ2   dq   64m   1.91nH   0.31pF
F7   DQ1   dq   63m   1.85nH   0.31pF
F8   VSSQ   GND   77m   2.71nH   0.31pF
G1   NC   NC   NA   NA   NA
G2   NC   NC   NA   NA   NA
G7   NC   NC   NA   NA   NA
G8   NC   NC   NA   NA   NA
H1   NC   NC   NA   NA   NA
H2   VSS   GND   65m   1.86nH   0.30pF
H7   VDD   POWER   67m   1.97nH   0.35pF
H8   NC   NC   NA   NA   NA
J1   NC   NC   NA   NA   NA
J2   DQM   input   67m   1.98nH   0.29pF
J7   WE#   input2   68m   1.98nH   0.24pF
J8   CAS#   input   83m   2.86nH   0.28pF
K1   NC   NC   NA   NA   NA
K2   CLK   clk_input   71m   2.20nH   0.31pF
K7   RAS#   input   70m   2.10nH   0.35pF
K8   NC   NC   NA   NA   NA
L1   A12   input2   93m   3.23nH   0.42pF
L2   CKE   input   76m   2.50nH   0.38pF
L7   NC   NC   NA   NA   NA
L8   CS#   input   84m   3.02nH   0.33pF
M1   A11   input   91m   3.23nH   0.41pF
M2   A9   input   76m   2.37nH   0.40pF
M7   BA1   input   76m   2.47nH   0.40pF
M8   BA0   input   90m   3.33nH   0.36pF
N1   A8   input   90m   3.32nH   0.40pF
N2   A7   input   76m   2.46nH   0.40pF
N7   A0   input   78m   2.54nH   0.41pF
N8   A10   input   93m   3.43nH   0.41pF
P1   A6   input   90m   3.37nH   0.39pF
P2   A5   input   76m   2.52nH   0.39pF
P7   A2   input   78m   2.63nH   0.40pF
P8   A1   input   93m   3.52nH   0.41pF
Q1   A4   input   91m   3.49nH   0.37pF
Q2   VSS   GND   43m   1.49nH   0.35pF
Q7   VDD   POWER   40m   1.40nH   0.35pF
Q8   A3   input   93m   3.59nH   0.38p
| Models and submodels in the file (4): dq (I/O), input (Input), clk_input (Input), input2 (Input)
